* sar10_adc reference netlist (generated by gen/netlist.py)
.subckt sar10_comp INP INN CLK OUTP OUTN VDD VSS
XM0 TAIL CLK VSS VSS sky130_fd_pr__nfet_01v8 L=0.15 W=2 nf=1 ad=0.58 as=0.58 pd=4.58 ps=4.58 nrd=0.145 nrs=0.145 sa=0 sb=0 sd=0 mult=1 m=1
XM0B TAIL CLK VSS VSS sky130_fd_pr__nfet_01v8 L=0.15 W=2 nf=1 ad=0.58 as=0.58 pd=4.58 ps=4.58 nrd=0.145 nrs=0.145 sa=0 sb=0 sd=0 mult=1 m=1
XM1 XN INP TAIL VSS sky130_fd_pr__nfet_01v8 L=0.15 W=4 nf=1 ad=1.16 as=1.16 pd=8.58 ps=8.58 nrd=0.0725 nrs=0.0725 sa=0 sb=0 sd=0 mult=1 m=1
XM2 XP INN TAIL VSS sky130_fd_pr__nfet_01v8 L=0.15 W=4 nf=1 ad=1.16 as=1.16 pd=8.58 ps=8.58 nrd=0.0725 nrs=0.0725 sa=0 sb=0 sd=0 mult=1 m=1
XM3 OUTN OUTP XN VSS sky130_fd_pr__nfet_01v8 L=0.15 W=2 nf=1 ad=0.58 as=0.58 pd=4.58 ps=4.58 nrd=0.145 nrs=0.145 sa=0 sb=0 sd=0 mult=1 m=1
XM4 OUTP OUTN XP VSS sky130_fd_pr__nfet_01v8 L=0.15 W=2 nf=1 ad=0.58 as=0.58 pd=4.58 ps=4.58 nrd=0.145 nrs=0.145 sa=0 sb=0 sd=0 mult=1 m=1
XM5 OUTN OUTP VDD VDD sky130_fd_pr__pfet_01v8 L=0.15 W=2 nf=1 ad=0.58 as=0.58 pd=4.58 ps=4.58 nrd=0.145 nrs=0.145 sa=0 sb=0 sd=0 mult=1 m=1
XM6 OUTP OUTN VDD VDD sky130_fd_pr__pfet_01v8 L=0.15 W=2 nf=1 ad=0.58 as=0.58 pd=4.58 ps=4.58 nrd=0.145 nrs=0.145 sa=0 sb=0 sd=0 mult=1 m=1
XM7 OUTN CLK VDD VDD sky130_fd_pr__pfet_01v8 L=0.15 W=1 nf=1 ad=0.29 as=0.29 pd=2.58 ps=2.58 nrd=0.29 nrs=0.29 sa=0 sb=0 sd=0 mult=1 m=1
XM8 OUTP CLK VDD VDD sky130_fd_pr__pfet_01v8 L=0.15 W=1 nf=1 ad=0.29 as=0.29 pd=2.58 ps=2.58 nrd=0.29 nrs=0.29 sa=0 sb=0 sd=0 mult=1 m=1
XM9 XN CLK VDD VDD sky130_fd_pr__pfet_01v8 L=0.15 W=1 nf=1 ad=0.29 as=0.29 pd=2.58 ps=2.58 nrd=0.29 nrs=0.29 sa=0 sb=0 sd=0 mult=1 m=1
XM10 XP CLK VDD VDD sky130_fd_pr__pfet_01v8 L=0.15 W=1 nf=1 ad=0.29 as=0.29 pd=2.58 ps=2.58 nrd=0.29 nrs=0.29 sa=0 sb=0 sd=0 mult=1 m=1
.ends

.subckt sar10_boot VIN VOUT VDD CK VSS
XMPI CKB CK VDD VDD sky130_fd_pr__pfet_01v8 L=0.15 W=6 nf=1 ad=1.74 as=1.74 pd=12.58 ps=12.58 nrd=0.0483333 nrs=0.0483333 sa=0 sb=0 sd=0 mult=1 m=1
XMNI CKB CK VSS VSS sky130_fd_pr__nfet_01v8 L=0.15 W=3 nf=1 ad=0.87 as=0.87 pd=6.58 ps=6.58 nrd=0.0966667 nrs=0.0966667 sa=0 sb=0 sd=0 mult=1 m=1
XMP1 TOP G VDD TOP sky130_fd_pr__pfet_01v8 L=0.15 W=2 nf=1 ad=0.58 as=0.58 pd=4.58 ps=4.58 nrd=0.145 nrs=0.145 sa=0 sb=0 sd=0 mult=1 m=1
XCB TOP BOT sky130_fd_pr__cap_mim_m3_1 W=9 L=9 MF=1 m=1
XMN1 BOT CKB VSS VSS sky130_fd_pr__nfet_01v8 L=0.15 W=2 nf=1 ad=0.58 as=0.58 pd=4.58 ps=4.58 nrd=0.145 nrs=0.145 sa=0 sb=0 sd=0 mult=1 m=1
XMP4 Z CK VDD VDD sky130_fd_pr__pfet_01v8 L=0.15 W=6 nf=1 ad=1.74 as=1.74 pd=12.58 ps=12.58 nrd=0.0483333 nrs=0.0483333 sa=0 sb=0 sd=0 mult=1 m=1
XMN4 Z CK BOT VSS sky130_fd_pr__nfet_01v8 L=0.15 W=1 nf=1 ad=0.29 as=0.29 pd=2.58 ps=2.58 nrd=0.29 nrs=0.29 sa=0 sb=0 sd=0 mult=1 m=1
XMN4B Z G BOT VSS sky130_fd_pr__nfet_01v8 L=0.15 W=1 nf=1 ad=0.29 as=0.29 pd=2.58 ps=2.58 nrd=0.29 nrs=0.29 sa=0 sb=0 sd=0 mult=1 m=1
XMP2 G Z TOP TOP sky130_fd_pr__pfet_01v8 L=0.15 W=4 nf=1 ad=1.16 as=1.16 pd=8.58 ps=8.58 nrd=0.0725 nrs=0.0725 sa=0 sb=0 sd=0 mult=1 m=1
XMN3 BOT G VIN VSS sky130_fd_pr__nfet_01v8 L=0.15 W=4 nf=1 ad=1.16 as=1.16 pd=8.58 ps=8.58 nrd=0.0725 nrs=0.0725 sa=0 sb=0 sd=0 mult=1 m=1
XMN2A G VDD GX VSS sky130_fd_pr__nfet_01v8 L=0.15 W=12 nf=1 ad=3.48 as=3.48 pd=24.58 ps=24.58 nrd=0.0241667 nrs=0.0241667 sa=0 sb=0 sd=0 mult=1 m=1
XMN2 GX CKB VSS VSS sky130_fd_pr__nfet_01v8 L=0.15 W=12 nf=1 ad=3.48 as=3.48 pd=24.58 ps=24.58 nrd=0.0241667 nrs=0.0241667 sa=0 sb=0 sd=0 mult=1 m=1
XMSW VOUT G VIN VSS sky130_fd_pr__nfet_01v8 L=0.15 W=5 nf=2 ad=0.725 as=1.45 pd=5.58 ps=11.16 nrd=0.058 nrs=0.058 sa=0 sb=0 sd=0 mult=1 m=1
.ends

.subckt sar10_dac128 DH DL TOP VDD VREFP VREFN VSS
XMP3H BH DH VREFP VREFP sky130_fd_pr__pfet_01v8 L=0.15 W=14.4 nf=3 ad=2.784 as=2.784 pd=20.36 ps=20.36 nrd=0.0201389 nrs=0.0201389 sa=0 sb=0 sd=0 mult=1 m=1
XMN3H BH DH VREFN VREFN sky130_fd_pr__nfet_01v8 L=0.15 W=5.76 nf=2 ad=0.8352 as=1.6704 pd=6.34 ps=12.68 nrd=0.0503472 nrs=0.0503472 sa=0 sb=0 sd=0 mult=1 m=1
XMP3L BL DL VREFP VREFP sky130_fd_pr__pfet_01v8 L=0.15 W=14.4 nf=3 ad=2.784 as=2.784 pd=20.36 ps=20.36 nrd=0.0201389 nrs=0.0201389 sa=0 sb=0 sd=0 mult=1 m=1
XMN3L BL DL VREFN VREFN sky130_fd_pr__nfet_01v8 L=0.15 W=5.76 nf=2 ad=0.8352 as=1.6704 pd=6.34 ps=12.68 nrd=0.0503472 nrs=0.0503472 sa=0 sb=0 sd=0 mult=1 m=1
XCH BH TOP VSS sky130_fd_pr__cap_vpp_01p8x01p8_m1m2_noshield mult=128 m=128
XCL BL TOP VSS sky130_fd_pr__cap_vpp_01p8x01p8_m1m2_noshield mult=128 m=128
.ends

.subckt sar10_dac64 DH DL TOP VDD VREFP VREFN VSS
XMP3H BH DH VREFP VREFP sky130_fd_pr__pfet_01v8 L=0.15 W=7.2 nf=2 ad=1.044 as=2.088 pd=7.78 ps=15.56 nrd=0.0402778 nrs=0.0402778 sa=0 sb=0 sd=0 mult=1 m=1
XMN3H BH DH VREFN VREFN sky130_fd_pr__nfet_01v8 L=0.15 W=2.88 nf=1 ad=0.8352 as=0.8352 pd=6.34 ps=6.34 nrd=0.100694 nrs=0.100694 sa=0 sb=0 sd=0 mult=1 m=1
XMP3L BL DL VREFP VREFP sky130_fd_pr__pfet_01v8 L=0.15 W=7.2 nf=2 ad=1.044 as=2.088 pd=7.78 ps=15.56 nrd=0.0402778 nrs=0.0402778 sa=0 sb=0 sd=0 mult=1 m=1
XMN3L BL DL VREFN VREFN sky130_fd_pr__nfet_01v8 L=0.15 W=2.88 nf=1 ad=0.8352 as=0.8352 pd=6.34 ps=6.34 nrd=0.100694 nrs=0.100694 sa=0 sb=0 sd=0 mult=1 m=1
XCH BH TOP VSS sky130_fd_pr__cap_vpp_01p8x01p8_m1m2_noshield mult=64 m=64
XCL BL TOP VSS sky130_fd_pr__cap_vpp_01p8x01p8_m1m2_noshield mult=64 m=64
.ends

.subckt sar10_dac32 DH DL TOP VDD VREFP VREFN VSS
XMP3H BH DH VREFP VREFP sky130_fd_pr__pfet_01v8 L=0.15 W=3.6 nf=1 ad=1.044 as=1.044 pd=7.78 ps=7.78 nrd=0.0805556 nrs=0.0805556 sa=0 sb=0 sd=0 mult=1 m=1
XMN3H BH DH VREFN VREFN sky130_fd_pr__nfet_01v8 L=0.15 W=1.44 nf=1 ad=0.4176 as=0.4176 pd=3.46 ps=3.46 nrd=0.201389 nrs=0.201389 sa=0 sb=0 sd=0 mult=1 m=1
XMP3L BL DL VREFP VREFP sky130_fd_pr__pfet_01v8 L=0.15 W=3.6 nf=1 ad=1.044 as=1.044 pd=7.78 ps=7.78 nrd=0.0805556 nrs=0.0805556 sa=0 sb=0 sd=0 mult=1 m=1
XMN3L BL DL VREFN VREFN sky130_fd_pr__nfet_01v8 L=0.15 W=1.44 nf=1 ad=0.4176 as=0.4176 pd=3.46 ps=3.46 nrd=0.201389 nrs=0.201389 sa=0 sb=0 sd=0 mult=1 m=1
XCH BH TOP VSS sky130_fd_pr__cap_vpp_01p8x01p8_m1m2_noshield mult=32 m=32
XCL BL TOP VSS sky130_fd_pr__cap_vpp_01p8x01p8_m1m2_noshield mult=32 m=32
.ends

.subckt sar10_dac16 DH DL TOP VDD VREFP VREFN VSS
XMP3H BH DH VREFP VREFP sky130_fd_pr__pfet_01v8 L=0.15 W=1.8 nf=1 ad=0.522 as=0.522 pd=4.18 ps=4.18 nrd=0.161111 nrs=0.161111 sa=0 sb=0 sd=0 mult=1 m=1
XMN3H BH DH VREFN VREFN sky130_fd_pr__nfet_01v8 L=0.15 W=0.72 nf=1 ad=0.2088 as=0.2088 pd=2.02 ps=2.02 nrd=0.402778 nrs=0.402778 sa=0 sb=0 sd=0 mult=1 m=1
XMP3L BL DL VREFP VREFP sky130_fd_pr__pfet_01v8 L=0.15 W=1.8 nf=1 ad=0.522 as=0.522 pd=4.18 ps=4.18 nrd=0.161111 nrs=0.161111 sa=0 sb=0 sd=0 mult=1 m=1
XMN3L BL DL VREFN VREFN sky130_fd_pr__nfet_01v8 L=0.15 W=0.72 nf=1 ad=0.2088 as=0.2088 pd=2.02 ps=2.02 nrd=0.402778 nrs=0.402778 sa=0 sb=0 sd=0 mult=1 m=1
XCH BH TOP VSS sky130_fd_pr__cap_vpp_01p8x01p8_m1m2_noshield mult=16 m=16
XCL BL TOP VSS sky130_fd_pr__cap_vpp_01p8x01p8_m1m2_noshield mult=16 m=16
.ends

.subckt sar10_dac8 DH DL TOP VDD VREFP VREFN VSS
XMP3H BH DH VREFP VREFP sky130_fd_pr__pfet_01v8 L=0.15 W=1.05 nf=1 ad=0.3045 as=0.3045 pd=2.68 ps=2.68 nrd=0.27619 nrs=0.27619 sa=0 sb=0 sd=0 mult=1 m=1
XMN3H BH DH VREFN VREFN sky130_fd_pr__nfet_01v8 L=0.15 W=0.42 nf=1 ad=0.1218 as=0.1218 pd=1.42 ps=1.42 nrd=0.690476 nrs=0.690476 sa=0 sb=0 sd=0 mult=1 m=1
XMP3L BL DL VREFP VREFP sky130_fd_pr__pfet_01v8 L=0.15 W=1.05 nf=1 ad=0.3045 as=0.3045 pd=2.68 ps=2.68 nrd=0.27619 nrs=0.27619 sa=0 sb=0 sd=0 mult=1 m=1
XMN3L BL DL VREFN VREFN sky130_fd_pr__nfet_01v8 L=0.15 W=0.42 nf=1 ad=0.1218 as=0.1218 pd=1.42 ps=1.42 nrd=0.690476 nrs=0.690476 sa=0 sb=0 sd=0 mult=1 m=1
XCH BH TOP VSS sky130_fd_pr__cap_vpp_01p8x01p8_m1m2_noshield mult=8 m=8
XCL BL TOP VSS sky130_fd_pr__cap_vpp_01p8x01p8_m1m2_noshield mult=8 m=8
.ends

.subckt sar10_dac4 DH DL TOP VDD VREFP VREFN VSS
XMP3H BH DH VREFP VREFP sky130_fd_pr__pfet_01v8 L=0.15 W=1.05 nf=1 ad=0.3045 as=0.3045 pd=2.68 ps=2.68 nrd=0.27619 nrs=0.27619 sa=0 sb=0 sd=0 mult=1 m=1
XMN3H BH DH VREFN VREFN sky130_fd_pr__nfet_01v8 L=0.15 W=0.42 nf=1 ad=0.1218 as=0.1218 pd=1.42 ps=1.42 nrd=0.690476 nrs=0.690476 sa=0 sb=0 sd=0 mult=1 m=1
XMP3L BL DL VREFP VREFP sky130_fd_pr__pfet_01v8 L=0.15 W=1.05 nf=1 ad=0.3045 as=0.3045 pd=2.68 ps=2.68 nrd=0.27619 nrs=0.27619 sa=0 sb=0 sd=0 mult=1 m=1
XMN3L BL DL VREFN VREFN sky130_fd_pr__nfet_01v8 L=0.15 W=0.42 nf=1 ad=0.1218 as=0.1218 pd=1.42 ps=1.42 nrd=0.690476 nrs=0.690476 sa=0 sb=0 sd=0 mult=1 m=1
XCH BH TOP VSS sky130_fd_pr__cap_vpp_01p8x01p8_m1m2_noshield mult=4 m=4
XCL BL TOP VSS sky130_fd_pr__cap_vpp_01p8x01p8_m1m2_noshield mult=4 m=4
.ends

.subckt sar10_dac2 DH DL TOP VDD VREFP VREFN VSS
XMP3H BH DH VREFP VREFP sky130_fd_pr__pfet_01v8 L=0.15 W=1.05 nf=1 ad=0.3045 as=0.3045 pd=2.68 ps=2.68 nrd=0.27619 nrs=0.27619 sa=0 sb=0 sd=0 mult=1 m=1
XMN3H BH DH VREFN VREFN sky130_fd_pr__nfet_01v8 L=0.15 W=0.42 nf=1 ad=0.1218 as=0.1218 pd=1.42 ps=1.42 nrd=0.690476 nrs=0.690476 sa=0 sb=0 sd=0 mult=1 m=1
XMP3L BL DL VREFP VREFP sky130_fd_pr__pfet_01v8 L=0.15 W=1.05 nf=1 ad=0.3045 as=0.3045 pd=2.68 ps=2.68 nrd=0.27619 nrs=0.27619 sa=0 sb=0 sd=0 mult=1 m=1
XMN3L BL DL VREFN VREFN sky130_fd_pr__nfet_01v8 L=0.15 W=0.42 nf=1 ad=0.1218 as=0.1218 pd=1.42 ps=1.42 nrd=0.690476 nrs=0.690476 sa=0 sb=0 sd=0 mult=1 m=1
XCH BH TOP VSS sky130_fd_pr__cap_vpp_01p8x01p8_m1m2_noshield mult=2 m=2
XCL BL TOP VSS sky130_fd_pr__cap_vpp_01p8x01p8_m1m2_noshield mult=2 m=2
.ends

.subckt sar10_dac1 DH DL TOP VDD VREFP VREFN VSS
XMP3H BH DH VREFP VREFP sky130_fd_pr__pfet_01v8 L=0.15 W=1.05 nf=1 ad=0.3045 as=0.3045 pd=2.68 ps=2.68 nrd=0.27619 nrs=0.27619 sa=0 sb=0 sd=0 mult=1 m=1
XMN3H BH DH VREFN VREFN sky130_fd_pr__nfet_01v8 L=0.15 W=0.42 nf=1 ad=0.1218 as=0.1218 pd=1.42 ps=1.42 nrd=0.690476 nrs=0.690476 sa=0 sb=0 sd=0 mult=1 m=1
XMP3L BL DL VREFP VREFP sky130_fd_pr__pfet_01v8 L=0.15 W=1.05 nf=1 ad=0.3045 as=0.3045 pd=2.68 ps=2.68 nrd=0.27619 nrs=0.27619 sa=0 sb=0 sd=0 mult=1 m=1
XMN3L BL DL VREFN VREFN sky130_fd_pr__nfet_01v8 L=0.15 W=0.42 nf=1 ad=0.1218 as=0.1218 pd=1.42 ps=1.42 nrd=0.690476 nrs=0.690476 sa=0 sb=0 sd=0 mult=1 m=1
XCH BH TOP VSS sky130_fd_pr__cap_vpp_01p8x01p8_m1m2_noshield mult=1 m=1
XCL BL TOP VSS sky130_fd_pr__cap_vpp_01p8x01p8_m1m2_noshield mult=1 m=1
.ends

.subckt sar10_dacdum TOP VREFP VREFN VSS
XCH VREFP TOP VSS sky130_fd_pr__cap_vpp_01p8x01p8_m1m2_noshield mult=1 m=1
XCL VREFN TOP VSS sky130_fd_pr__cap_vpp_01p8x01p8_m1m2_noshield mult=1 m=1
.ends

.subckt sar10_slice TPREV QP QN VALIDB RSTB EOC T DEC DP DPB DN DNB B VDD VSS
xlpb QP TPREV TB LP VSS VSS VDD VDD LPB sky130_fd_sc_hd__a31oi_1
xlp LPB RSTB VSS VSS VDD VDD LP sky130_fd_sc_hd__nor2b_1
xlnb QN TPREV TB LN VSS VSS VDD VDD LNB sky130_fd_sc_hd__a31oi_1
xln LNB RSTB VSS VSS VDD VDD LN sky130_fd_sc_hd__nor2b_1
xdec LPB LNB VSS VSS VDD VDD DEC sky130_fd_sc_hd__nand2_1
xst DEC VALIDB TB VSS VSS VDD VDD STB sky130_fd_sc_hd__nand3_1
xt STB TB VSS VSS VDD VDD T sky130_fd_sc_hd__nand2_1
xtb T DEC VSS VSS VDD VDD TB sky130_fd_sc_hd__nand2_1
xb EOC LP VSS VSS VDD VDD B sky130_fd_sc_hd__dfxtp_1
xgdp LPB VSS VSS VDD VDD DP sky130_fd_sc_hd__inv_4
xadpb LPB VSS VSS VDD VDD ADPB sky130_fd_sc_hd__inv_1
xgdpb ADPB VSS VSS VDD VDD DPB sky130_fd_sc_hd__inv_4
xgdn LNB VSS VSS VDD VDD DN sky130_fd_sc_hd__inv_4
xadnb LNB VSS VSS VDD VDD ADNB sky130_fd_sc_hd__inv_1
xgdnb ADNB VSS VSS VDD VDD DNB sky130_fd_sc_hd__inv_4
.ends

.subckt sar10_ctrl OUTP OUTN CLKS DECL CLKC QP QN VALIDB RSTB SAMP EOC VDD VSS
xs1 CLKS VSS VSS VDD VDD SB1 sky130_fd_sc_hd__inv_1
xs2 SB1 VSS VSS VDD VDD SAMP sky130_fd_sc_hd__inv_4
xr3 CLKS VSS VSS VDD VDD RSTB sky130_fd_sc_hd__inv_4
xsd RSTB VSS VSS VDD VDD SAMPD sky130_fd_sc_hd__inv_1
xrun SAMPD DECL VSS VSS VDD VDD RUN sky130_fd_sc_hd__nor2_1
xqp OUTN VSS VSS VDD VDD QP sky130_fd_sc_hd__inv_4
xv OUTN OUTP VSS VSS VDD VDD VALID sky130_fd_sc_hd__nand2_1
xqn OUTP VSS VSS VDD VDD QN sky130_fd_sc_hd__inv_4
xvb VALID VSS VSS VDD VDD VALIDB sky130_fd_sc_hd__inv_4
xd1 VALIDB VSS VSS VDD VDD DL1 sky130_fd_sc_hd__inv_1
xd2 DL1 VSS VSS VDD VDD VD sky130_fd_sc_hd__inv_1
xg RUN VD VALIDB VSS VSS VDD VDD CLKCB sky130_fd_sc_hd__nand3_1
xgb CLKCB VSS VSS VDD VDD CLKC sky130_fd_sc_hd__inv_4
xe DECL VSS VSS VDD VDD EOC sky130_fd_sc_hd__buf_4
.ends

.subckt sar10_adc VIP VIN CLK B9 B8 B7 B6 B5 B4 B3 B2 B1 B0 EOC VDD VREFP VREFN VSS
XBSP VIP TOPP VDD SAMP VSS sar10_boot
XBSN VIN TOPN VDD SAMP VSS sar10_boot
XDP1 DP1 DNB1 TOPP VDD VREFP VREFN VSS sar10_dac128
XDN1 DN1 DPB1 TOPN VDD VREFP VREFN VSS sar10_dac128
XDP2 DP2 DNB2 TOPP VDD VREFP VREFN VSS sar10_dac64
XDN2 DN2 DPB2 TOPN VDD VREFP VREFN VSS sar10_dac64
XDP3 DP3 DNB3 TOPP VDD VREFP VREFN VSS sar10_dac32
XDN3 DN3 DPB3 TOPN VDD VREFP VREFN VSS sar10_dac32
XDP4 DP4 DNB4 TOPP VDD VREFP VREFN VSS sar10_dac16
XDN4 DN4 DPB4 TOPN VDD VREFP VREFN VSS sar10_dac16
XDP5 DP5 DNB5 TOPP VDD VREFP VREFN VSS sar10_dac8
XDN5 DN5 DPB5 TOPN VDD VREFP VREFN VSS sar10_dac8
XDP6 DP6 DNB6 TOPP VDD VREFP VREFN VSS sar10_dac4
XDN6 DN6 DPB6 TOPN VDD VREFP VREFN VSS sar10_dac4
XDP7 DP7 DNB7 TOPP VDD VREFP VREFN VSS sar10_dac2
XDN7 DN7 DPB7 TOPN VDD VREFP VREFN VSS sar10_dac2
XDP8 DP8 DNB8 TOPP VDD VREFP VREFN VSS sar10_dac1
XDN8 DN8 DPB8 TOPN VDD VREFP VREFN VSS sar10_dac1
XDP9 DP9 DNB9 TOPP VDD VREFP VREFN VSS sar10_dac1
XDN9 TOPN VREFP VREFN VSS sar10_dacdum
XCMP TOPP TOPN CLKC OUTP OUTN VDD VSS sar10_comp
XCTL OUTP OUTN CLK DEC10 CLKC QP QN VALIDB RSTB SAMP EOC VDD VSS sar10_ctrl
XS1 RSTB QP QN VALIDB RSTB EOC T1 DEC1 DP1 DPB1 DN1 DNB1 B9 VDD VSS sar10_slice
XS2 T1 QP QN VALIDB RSTB EOC T2 DEC2 DP2 DPB2 DN2 DNB2 B8 VDD VSS sar10_slice
XS3 T2 QP QN VALIDB RSTB EOC T3 DEC3 DP3 DPB3 DN3 DNB3 B7 VDD VSS sar10_slice
XS4 T3 QP QN VALIDB RSTB EOC T4 DEC4 DP4 DPB4 DN4 DNB4 B6 VDD VSS sar10_slice
XS5 T4 QP QN VALIDB RSTB EOC T5 DEC5 DP5 DPB5 DN5 DNB5 B5 VDD VSS sar10_slice
XS6 T5 QP QN VALIDB RSTB EOC T6 DEC6 DP6 DPB6 DN6 DNB6 B4 VDD VSS sar10_slice
XS7 T6 QP QN VALIDB RSTB EOC T7 DEC7 DP7 DPB7 DN7 DNB7 B3 VDD VSS sar10_slice
XS8 T7 QP QN VALIDB RSTB EOC T8 DEC8 DP8 DPB8 DN8 DNB8 B2 VDD VSS sar10_slice
XS9 T8 QP QN VALIDB RSTB EOC T9 DEC9 DP9 DPB9 DN9 DNB9 B1 VDD VSS sar10_slice
XS10 T9 QP QN VALIDB RSTB EOC T10 DEC10 DP10 DPB10 DN10 DNB10 B0 VDD VSS sar10_slice
.ends
